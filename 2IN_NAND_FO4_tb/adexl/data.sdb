ADE simulation setup
Run mode: Single Run, Sweeps and Corners
Tests:
  my_library:2IN_NAND_FO4_tb:1: my_library/2IN_NAND_FO4_tb/schematic, simulator spectre
    Outputs: ((tplh + tphl) / 2)
Global variables:
  H = 4
  k = 1:0.25:3
  VIN = 0
