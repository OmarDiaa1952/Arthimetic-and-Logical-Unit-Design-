ADE simulation setup
Run mode: Single Run, Sweeps and Corners
Tests:
  my_library:2IN_NAND_tb:1: my_library/2IN_NAND_tb/schematic, simulator spectre
Global variables:
  VIN = 0
  k = 2
